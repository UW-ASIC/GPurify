* LVS_INV's inverter drawn as devices, plus a second inverter the schematic
* places by instance and the layout does not draw. It must not match: the
* layout is missing a block (testing-plan F1).
.subckt INV A Y VDD VSS
M0 Y A VSS VSS nfet_01v8
M1 Y A VDD VDD pfet_01v8
.ends
.subckt TOP A Y VDD VSS
M0 Y A VSS VSS nfet_01v8
M1 Y A VDD VDD pfet_01v8
X2 Y A VDD VSS INV
.ends
